* HS-200 humidity sensor analog front end (PSpice)
* Hanbit Sensor, rev B. CF is a TDK C1608C0G1H100D080AA (10 pF, 50 V, C0G, 1608).
.LIB "HS-200.lib"
.PARAM RF=100k
.PARAM VSUP=5V
V_VSUP VP 0 DC {VSUP}
V_VREF VREF 0 DC {VSUP/2}
V_SENS SENS VREF AC 1 SIN(0 50m 1k)
R_RIN SENS N1 10k TC=0,0
R_RF N1 OUT {RF} TC=0,0
C_CF N1 OUT 10p
X_U1 VREF N1 OUT VP 0 HSOPA
R_RF2 OUT FLT 1k
C_CF2 FLT VREF 1n IC=0
R_LOAD FLT VREF 100k
.STEP PARAM RF LIST 100k 220k
.TRAN 0 5ms
.AC DEC 40 10 10MEG
.PROBE V(alias(*)) I(alias(*))
.END
